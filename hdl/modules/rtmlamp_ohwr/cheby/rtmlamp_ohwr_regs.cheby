memory-map:
  bus: wb-32-be
  name: wb_rtmlamp_ohwr_regs
  description: RTM LAMP registers
  comment: |
    Wishbone slave for RTM LAMP core
  x-hdl:
    busgroup: True
  children:
    - reg:
        name: sta
        width: 32
        access: ro
        address: 0x00000000
        description: General RTM status register
        comment: |
          General RTM status register
        children:
          - field:
              name: reserved
              range: 31-0
              description: reserved
              comment: |
                reserved
    - reg:
        name: ctl
        width: 32
        access: rw
        address: 0x00000004
        description: General RTM control register
        comment: |
          General RTM control register
        children:
          - field:
              name: reserved
              range: 31-0
              description: reserved
              comment: |
                reserved
    - repeat:
        name: ch
        count: 12
        size: 64
        x-hdl:
          iogroup: rtmlamp_ohwr_ch_regs
        children:
          - reg:
              name: sta
              width: 32
              access: ro
              description: Channel status register
              comment: |
                Channel status register
              children:
                - field:
                    name: amp_iflag_l
                    range: 0
                    description: Amplifier Left Current Limit Flag (IFLAG_L)
                    comment: |
                      read 0: current above limit
                      read 1: current under limit
                - field:
                    name: amp_tflag_l
                    range: 1
                    description: Amplifier Left Thermal Limit Flag (TFLAG_L)
                    comment: |
                      read 0: temperature above limit
                      read 1: temperature under limit
                - field:
                    name: amp_iflag_r
                    range: 2
                    description: Amplifier Right Current Limit Flag (IFLAG_R)
                    comment: |
                      read 0: current above limit
                      read 1: current under limit
                - field:
                    name: amp_tflag_r
                    range: 3
                    description: Amplifier Right Thermal Limit Flag (TFLAG_R)
                    comment: |
                      read 0: temperature above limit
                      read 1: temperature under limit
                - field:
                    name: amp_iflag_l_latch
                    range: 16
                    description: Amplifier Left Current Limit Flag (IFLAG_L)
                    comment: |
                      read 0: current above limit
                      read 1: current under limit
                      This flag is a latch, and should be cleared manually by
                      writing '1' to ctl.rst_latch_sts.
                - field:
                    name: amp_tflag_l_latch
                    range: 17
                    description: Amplifier Left Thermal Limit Flag (TFLAG_L)
                    comment: |
                      read 0: temperature above limit
                      read 1: temperature under limit
                      This flag is a latch, and should be cleared manually by
                      writing '1' to ctl.rst_latch_sts.
                - field:
                    name: amp_iflag_r_latch
                    range: 18
                    description: Amplifier Right Current Limit Flag (IFLAG_R)
                    comment: |
                      read 0: current above limit
                      read 1: current under limit
                      This flag is a latch, and should be cleared manually by
                      writing '1' to ctl.rst_latch_sts.
                - field:
                    name: amp_tflag_r_latch
                    range: 19
                    description: Amplifier Right Thermal Limit Flag (TFLAG_R)
                    comment: |
                      read 0: temperature above limit
                      read 1: temperature under limit
                      This flag is a latch, and should be cleared manually by
                      writing '1' to ctl.rst_latch_sts.
          - reg:
              name: ctl
              width: 32
              access: rw
              description: Channel control register
              comment: |
                Channel control register
              children:
                - field:
                    name: amp_en
                    range: 0
                    description: Amplifier Enable
                    comment: |
                      write 0: disable amplifier
                      write 1: enable amplifier
                - field:
                    name: mode
                    range: 3-1
                    description: Power supply operation mode
                    comment: |
                      000: Open loop (voltage) manual control via dac
                      001: Open loop (voltage) test square wave
                      010: Closed loop (current) manual control via pi_sp
                      011: Closed loop (current) test square wave
                      100: Closed loop (current) external control
                      101: reserved
                      110: reserved
                      111: reserved
                - field:
                    name: trig_en
                    range: 5
                    description: Triggered mode enable
                    comment: |
                      write 0: Triggered mode disabled
                      write 1: Triggered mode enabled, all set-points sent when in manual
                               mode (open loop and closed loop) will only become effective
                               after an external trigger is received. It is ignored when in
                               the test square wave modes.
                - field:
                    name: rst_latch_sts
                    range: 6
                    x-hdl:
                      type: autoclear
                    description: Reset latched status bits
                    comment: |
                      write 0: do nothing
                      write 1: Reset latched status bits (autoclear)
                - field:
                    name: amp_iflag_l_trig_mask
                    range: 25
                    description: Left Amplifier Over-Current Trigger Mask
                    comment: |
                      write 0: Trigger generation disabled
                      write 1: Generate a trigger event if the flag is asserted
                - field:
                    name: amp_tflag_l_trig_mask
                    range: 26
                    description: Left Amplifier Over-Temperature Trigger Mask
                    comment: |
                      write 0: Trigger generation disabled
                      write 1: Generate a trigger event if the flag is asserted
                - field:
                    name: amp_iflag_r_trig_mask
                    range: 27
                    description: Right Amplifier Over-Current Trigger Mask
                    comment: |
                      write 0: Trigger generation disabled
                      write 1: Generate a trigger event if the flag is asserted
                - field:
                    name: amp_tflag_r_trig_mask
                    range: 28
                    description: Right Amplifier Over-Temperature Trigger Mask
                    comment: |
                      write 0: Trigger generation disabled
                      write 1: Generate a trigger event if the flag is asserted
          - reg:
              name: pi_kp
              width: 32
              access: rw
              description: PI KP parameter
              comment: |
                PI KP parameter
              children:
                - field:
                    name: data
                    range: 25-0
                    description: PI KP
                    comment: |
                      PI KP
          - reg:
              name: pi_ti
              width: 32
              access: rw
              description: PI TI parameter
              comment: |
                PI TI parameter
              children:
                - field:
                    name: data
                    range: 25-0
                    description: PI TI
                    comment: |
                      PI TI
          - reg:
              name: pi_sp
              width: 32
              access: rw
              description: PI Setpoint parameter
              comment: |
                PI SP parameter
              children:
                - field:
                    name: data
                    range: 15-0
                    description: PI SP
                    comment: |
                      PI SP
          - reg:
              name: dac
              width: 32
              access: rw
              description: DAC channel control register
              comment: |
                DAC channel control register
              children:
                - field:
                    name: data
                    range: 15-0
                    description: DAC data
                    comment: |
                      Write DAC data for channel
          - reg:
              name: lim
              width: 32
              access: rw
              description: Channel square wave limits
              comment: |
                Channel square wave limits
              children:
                - field:
                    name: a
                    range: 15-0
                    description: Signed limit 'a'
                    comment: |
                      This is used only in Open Loop / Closed Loop test square wave modes.
                      It can represent a current in ADC counts or a voltage in DAC counts.
                - field:
                    name: b
                    range: 31-16
                    description: Signed limit 'b'
                    comment: |
                      This is used only in Open Loop / Closed Loop test square wave modes.
                      It can represent a current in ADC counts or a voltage in DAC counts.
                      type: SLV
          - reg:
              name: cnt
              width: 32
              access: rw
              description: |
                Test mode period, in clock ticks.
              comment: |
                Test mode period, in clock ticks.
              children:
                - field:
                    name: data
                    range: 21-0
                    description: Test mode period, in clock ticks
          - reg:
              name: adc_dac_eff
              width: 32
              access: ro
              description: |
                ADC and DAC instantaneous value (2's complement)
              comment: |
                ADC and DAC instantaneous value (2's complement)
              children:
                - field:
                    name: adc
                    range: 15-0
                    description: ADC instantaneous measurement
                - field:
                    name: dac
                    range: 31-16
                    description: DAC instantaneous effective data
                    comment: |
                      It is the actual value sent to the DAC irrespectively of operation mode
          - reg:
              name: sp_eff
              width: 32
              access: ro
              description: |
                Set point instantaneous value (2's complement)
              comment: |
                Set point instantaneous value (2's complement)
              children:
                - field:
                    name: sp
                    range: 15-0
                    description: Set point instantaneous effective data
                    comment: |
                      It is the actual value sent to the PI controller irrespectively of operation mode
